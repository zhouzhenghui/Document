[IBIS Ver]   3.2
[Comment Char]   |_char
[File Name]   mx28.ibs
[File Rev]   1.2
[Date]   2011/01/12-10:05:00
[Copyright]   Copyright (C) 2010 Freescale Semiconductor Ltd.
[Disclaimer]
[Source]   15-Oct09 RLC data
[Notes]   generated by ibis_writer(RyanLee b06542@freescale.com)
|   289MAPBGA14x14
[Component]   289MAPBGA14x14
[Manufacturer]   FREESCALE
[Package]
| variable   typ   min   max
R_pkg   133.32m   47.07m   1085.25m
L_pkg   3.69nH   0.84nH   54.43nH
C_pkg   0.16pF   0.07pF   0.30pF
[Pin]  signal_name   model_name   R_pin   L_pin   C_pin
A1   VSS   GND   102.24m   3.69nH   0.09pF
A2   SSP3_SCK   gpio_clk   208.98m   5.51nH   0.18pF
A3   SSP2_SCK   gpio_clk   212.45m   5.72nH   0.18pF
A4   SSP0_CMD   gpio_f   182.23m   4.80nH   0.16pF
A5   SSP0_DATA3   gpio_f   169.52m   4.31nH   0.19pF
A6   SSP0_SCK   gpio_clk   158.48m   4.00nH   0.15pF
A7   VDDIO33   POWER   92.30m   3.08nH   0.17pF
A8   USB1DP   GND   1085.25m   54.43nH   0.15pF
A9   VSS   GND   102.24m   3.69nH   0.09pF
A10   USB0DM   GND   129.39m   3.64nH   0.16pF
A11   PSWITCH   GND   150.67m   3.97nH   0.18pF
A12   XTALI   GND   146.80m   4.02nH   0.18pF
A13   VDD4P2   POWER   54.60m   3.15nH   0.21pF
A14   RESETN   GND   185.07m   5.66nH   0.20pF
A15   BATTERY   GND   85.45m   3.60nH   0.25pF
A16   DCDC_LP   GND   95.46m   3.68nH   0.17pF
A17   DCDC_GND   GND   100.06m   4.04nH   0.18pF
B1   SSP1_SCK   gpio_clk   227.38m   6.30nH   0.19pF
B2   SSP3_MISO   gpio   216.06m   5.52nH   0.22pF
B3   SSP2_MISO   gpio   201.10m   4.91nH   0.17pF
B4   SSP0_DATA7   gpio_clk   190.04m   4.71nH   0.19pF
B5   SSP0_DATA4   gpio_f   174.01m   4.18nH   0.16pF
B6   SSP0_DATA0   gpio_f   162.12m   3.88nH   0.15pF
B7   VSS   GND   102.24m   3.69nH   0.09pF
B8   USB1DM   GND   120.95m   3.01nH   0.15pF
B9   DEBUG   gpio   105.41m   2.83nH   0.20pF
B10   USB0DP   GND   127.68m   3.43nH   0.17pF
B11   VSSA2   GND   86.92m   2.44nH   0.15pF
B12   XTALO   GND   144.57m   3.84nH   0.18pF
B13   VSSA1   GND   59.43m   2.13nH   0.22pF
B14   HSADC0   GND   117.91m   3.76nH   0.20pF
B15   DCDC_BATT   GND   82.68m   3.07nH   0.17pF
B16   DCDC_VDDA   GND   89.89m   3.45nH   0.25pF
B17   DCDC_LN1   GND   75.30m   3.53nH   0.21pF
C1   SSP1_CMD   gpio   223.54m   6.15nH   0.19pF
C2   SSP3_MOSI   gpio   210.42m   5.38nH   0.20pF
C3   SSP2_MOSI   gpio   191.30m   4.51nH   0.18pF
C4   SSP2_SS0   gpio   114.05m   3.49nH   0.18pF
C5   SSP0_DATA5   gpio_f   157.32m   3.31nH   0.15pF
C6   SSP0_DATA1   gpio_f   83.99m   2.04nH   0.12pF
C7   I2C0_SCL   gpio   140.98m   2.91nH   0.11pF
C8   LRADC2   GND   140.76m   3.36nH   0.21pF
C9   LRADC1   GND   103.06m   2.43nH   0.16pF
C10   TESTMODE   gpio   72.71m   2.04nH   0.12pF
C11   RTC_XTALO   GND   107.93m   2.32nH   0.17pF
C12   VDDXTAL   POWER   148.51m   4.24nH   0.21pF
C13   VDDA1   POWER   79.14m   2.36nH   0.22pF
C14   LRADC6   GND   106.80m   2.90nH   0.19pF
C15   LRADC0   GND   139.40m   4.20nH   0.19pF
C16   VSS   GND   102.24m   3.69nH   0.09pF
C17   DCDC_VDDIO   GND   91.53m   3.53nH   0.17pF
D1   SSP1_DATA0   gpio   215.42m   5.82nH   0.19pF
D2   SSP3_SS0   gpio   200.60m   5.10nH   0.19pF
D3   SSP2_SS1   gpio   185.44m   4.43nH   0.19pF
D4   SSP2_SS2   gpio   114.63m   3.32nH   0.15pF
D5   SSP0_DATA6   gpio_f   83.43m   2.12nH   0.12pF
D6   SSP0_DATA2   gpio_f   88.76m   1.99nH   0.10pF
D7   SPDIF   gpio   79.93m   1.69nH   0.16pF
D8   I2C0_SDA   gpio   71.08m   1.50nH   0.10pF
D9   LRADC3   GND   103.54m   2.33nH   0.13pF
D10   SSP0_DETECT   gpio   77.89m   1.86nH   0.14pF
D11   RTC_XTALI   GND   113.68m   2.16nH   0.19pF
D12   JTAG_TMS   gpio   110.50m   3.21nH   0.30pF
D13   LRADC4   GND   123.46m   2.59nH   0.14pF
D14   JTAG_TRST   gpio   158.52m   3.76nH   0.17pF
D15   LRADC5   GND   141.73m   3.74nH   0.20pF
D16   VDD1P5   POWER   86.94m   3.05nH   0.20pF
D17   DCDC_VDDD   GND   99.18m   3.73nH   0.17pF
E1   SSP1_DATA3   gpio   205.79m   5.47nH   0.18pF
E2   ENET_CLK   gpio_clk   190.13m   4.80nH   0.18pF
E3   ENET0_TX_CLK   gpio_clk   180.02m   4.36nH   0.26pF
E4   ENET0_RX_EN   gpio   154.67m   3.55nH   0.14pF
E5   VSS   GND   102.24m   3.69nH   0.09pF
E6   VDDIO33   POWER   75.49m   1.69nH   0.10pF
E7   SAIF0_SDATA0   gpio   66.26m   1.24nH   0.11pF
E8   SAIF1_SDATA0   gpio   60.18m   1.18nH   0.10pF
E9   PWM3   gpio   86.97m   1.78nH   0.13pF
E10   PWM4   gpio   87.28m   1.95nH   0.14pF
E11   JTAG_TCK   gpio   113.71m   2.52nH   0.16pF
E12   JTAG_TDI   gpio   92.21m   2.60nH   0.21pF
E13   JTAG_TDO   gpio   60.86m   1.52nH   0.18pF
E14   JTAG_RTCK   gpio   145.82m   3.33nH   0.19pF
E15   VSS   GND   102.24m   3.69nH   0.09pF
E16   VDDIO33   POWER   140.26m   3.65nH   0.15pF
E17   VDD5V   POWER   95.66m   3.71nH   0.25pF
F1   ENET0_TXD0   gpio   195.98m   5.26nH   0.18pF
F2   ENET0_TXD1   gpio   181.60m   4.60nH   0.18pF
F3   ENET0_RX_CLK   gpio_clk   150.03m   3.50nH   0.18pF
F4   ENET0_TX_EN   gpio   152.36m   3.33nH   0.12pF
F5   AUART2_TX   gpio   70.59m   1.76nH   0.11pF
F6   AUART2_RX   gpio   70.96m   1.54nH   0.10pF
F7   SAIF0_BITCLK   gpio   56.68m   0.99nH   0.09pF
F8   VDDIO18   POWER   89.38m   2.59nH   0.07pF
F9   VDDIO18   POWER   89.38m   2.59nH   0.07pF
F10   VDDD   POWER   69.13m   2.11nH   0.08pF
F11   VDDD   POWER   69.13m   2.11nH   0.08pF
F12   VDDD   POWER   69.13m   2.11nH   0.08pF
F13   EMI_D14   ddr   82.55m   1.60nH   0.12pF
F14   VSSIO_EMI   GND   58.44m   1.65nH   0.11pF
F15   EMI_DQM1   ddr   130.49m   2.96nH   0.16pF
F16   VSSIO_EMI   GND   135.72m   3.40nH   0.15pF
F17   EMI_D15   ddr   156.31m   4.02nH   0.15pF
G1   ENET0_TXD2   gpio   194.23m   5.22nH   0.20pF
G2   ENET0_TXD3   gpio   178.47m   4.52nH   0.18pF
G3   VDDIO33   POWER   173.03m   4.65nH   0.20pF
G4   ENET0_MDC   gpio   99.92m   2.91nH   0.19pF
G5   AUART0_RX   gpio   71.50m   1.81nH   0.11pF
G6   SAIF0_LRCLK   gpio   67.45m   1.46nH   0.10pF
G7   SAIF0_MCLK   gpio   55.80m   0.97nH   0.09pF
G8   VDDIO18   POWER   89.38m   2.59nH   0.07pF
G9   VDDIO18   POWER   89.38m   2.59nH   0.07pF
G10   VDDD   POWER   69.13m   2.11nH   0.08pF
G11   VDDD   POWER   69.13m   2.11nH   0.08pF
G12   VDDD   POWER   69.13m   2.11nH   0.08pF
G13   VDDIO_EMI   POWER   96.79m   2.52nH   0.11pF
G14   EMI_D10   ddr   57.56m   1.46nH   0.10pF
G15   VDDIO_EMI   POWER   96.79m   2.52nH   0.11pF
G16   EMI_D08   ddr   142.76m   3.31nH   0.14pF
G17   VDDIO_EMI   POWER   96.79m   2.52nH   0.11pF
H1   ENET0_RXD0   gpio   194.89m   5.30nH   0.18pF
H2   ENET0_RXD1   gpio   179.17m   4.59nH   0.20pF
H3   VSS   GND   102.24m   3.69nH   0.09pF
H4   ENET0_MDIO   gpio   168.86m   3.96nH   0.19pF
H5   AUART0_TX   gpio   70.84m   1.82nH   0.11pF
H6   AUART2_CTS   gpio   65.39m   1.41nH   0.09pF
H7   AUART2_RTS   gpio   47.07m   0.84nH   0.09pF
H8   VDDIO33   POWER   66.03m   1.78nH   0.10pF
H9   VSS   GND   102.24m   3.69nH   0.09pF
H10   VSS   GND   102.24m   3.69nH   0.09pF
H11   VSS   GND   102.24m   3.69nH   0.09pF
H12   VSS   GND   102.24m   3.69nH   0.09pF
H13   EMI_D12   ddr   52.44m   0.91nH   0.08pF
H14   VSSIO_EMI   GND   53.37m   1.34nH   0.10pF
H15   EMI_D09   ddr   123.11m   2.54nH   0.15pF
H16   VSS   GND   102.24m   3.69nH   0.09pF
H17   EMI_D13   ddr   158.10m   3.93nH   0.14pF
J1   ENET0_RXD2   gpio   196.10m   5.30nH   0.21pF
J2   ENET0_RXD3   gpio   180.06m   4.60nH   0.17pF
J3   ENET0_CRS   gpio   149.40m   3.50nH   0.17pF
J4   ENET0_COL   gpio   145.44m   3.16nH   0.22pF
J5   AUART1_RTS   gpio   69.16m   1.76nH   0.12pF
J6   AUART0_CTS   gpio   65.80m   1.43nH   0.10pF
J7   AUART0_RTS   gpio   79.90m   1.79nH   0.13pF
J8   VDDIO33   POWER   66.03m   1.78nH   0.10pF
J9   VDDIO33   POWER   66.03m   1.78nH   0.10pF
J10   VDDIO33   POWER   66.03m   1.78nH   0.10pF
J11   VSS   GND   102.24m   3.69nH   0.09pF
J12   VSS   GND   102.24m   3.69nH   0.09pF
J13   VDDIO_EMIQ   POWER   50.21m   0.89nH   0.09pF
J14   EMI_D11   ddr   65.88m   1.43nH   0.09pF
J15   VSS   GND   102.24m   3.69nH   0.09pF
J16   EMI_DQS1N   ddr_clk   98.22m   2.72nH   0.18pF
J17   EMI_DQS1   ddr_clk   152.68m   3.78nH   0.16pF
K1   LCD_WR_RWN   gpio_clk   200.66m   5.45nH   0.22pF
K2   LCD_D00   gpio_f   186.08m   4.57nH   0.18pF
K3   LCD_D01   gpio_f   166.66m   3.96nH   0.18pF
K4   AUART1_TX   gpio   148.64m   3.29nH   0.12pF
K5   AUART1_CTS   gpio   68.59m   1.71nH   0.10pF
K6   AUART3_RTS   gpio   69.74m   1.51nH   0.10pF
K7   PWM0   gpio   50.84m   0.98nH   0.09pF
K8   PWM2   gpio   65.38m   1.39nH   0.12pF
K9   VSS   GND   102.24m   3.69nH   0.09pF
K10   VSS   GND   102.24m   3.69nH   0.09pF
K11   VSS   GND   102.24m   3.69nH   0.09pF
K12   VDDD   POWER   69.13m   2.11nH   0.08pF
K13   EMI_VREF1   POWER   53.27m   0.92nH   0.09pF
K14   EMI_DDR_OPEN   ddr   125.84m   2.26nH   0.10pF
K15   VDDIO_EMIQ   POWER   55.86m   1.60nH   0.19pF
K16   EMI_DQS0N   ddr_clk   94.31m   2.87nH   0.16pF
K17   EMI_DQS0   ddr_clk   158.75m   3.99nH   0.15pF
L1   LCD_VSYNC   gpio_f   206.78m   5.69nH   0.23pF
L2   LCD_D02   gpio_f   185.28m   4.85nH   0.18pF
L3   LCD_D03   gpio_f   172.74m   4.09nH   0.18pF
L4   AUART1_RX   gpio   158.23m   3.44nH   0.12pF
L5   AUART3_TX   gpio   71.81m   1.83nH   0.11pF
L6   AUART3_CTS   gpio   75.29m   1.67nH   0.10pF
L7   PWM1   gpio   60.42m   1.25nH   0.11pF
L8   GPMI_RDY3   gpio_f   75.93m   1.75nH   0.14pF
L9   GPMI_RESETN   gpio_f   52.52m   0.94nH   0.09pF
L10   VSS   GND   102.24m   3.69nH   0.09pF
L11   VSS   GND   102.24m   3.69nH   0.09pF
L12   VSSIO_EMI   GND   72.76m   1.46nH   0.13pF
L13   VDDIO_EMI   POWER   53.97m   1.09nH   0.09pF
L14   EMI_D06   ddr   149.47m   3.25nH   0.18pF
L15   EMI_DDR_OPEN_FB   ddr   126.75m   2.71nH   0.15pF
L16   EMI_CLKN   ddr_clk   110.47m   3.33nH   0.16pF
L17   EMI_CLK   ddr_clk   169.41m   4.30nH   0.15pF
M1   LCD_HSYNC   gpio_f   208.21m   5.68nH   0.19pF
M2   LCD_D04   gpio_f   195.70m   5.00nH   0.18pF
M3   LCD_D05   gpio_f   182.39m   4.32nH   0.18pF
M4   LCD_RS   gpio_f   104.52m   2.92nH   0.13pF
M5   AUART3_RX   gpio   74.00m   2.01nH   0.12pF
M6   LCD_RESET   gpio_f   62.24m   1.53nH   0.10pF
M7   GPMI_CE2N   gpio_f   69.53m   1.63nH   0.12pF
M8   GPMI_RDY2   gpio_f   83.43m   2.13nH   0.17pF
M9   GPMI_CE3N   gpio_f   66.64m   1.47nH   0.09pF
M10   VDDIO_EMI   POWER   56.36m   1.43nH   0.11pF
M11   VDDIO_EMI   POWER   73.97m   2.46nH   0.13pF
M12   VDDIO_EMI   POWER   73.97m   2.46nH   0.13pF
M13   EMI_D01   ddr   99.87m   2.54nH   0.19pF
M14   VSS   GND   102.24m   3.69nH   0.09pF
M15   EMI_DQM0   ddr   133.62m   2.92nH   0.16pF
M16   VSSIO_EMI   GND   143.23m   3.45nH   0.15pF
M17   EMI_D07   ddr   166.67m   4.27nH   0.15pF
N1   LCD_DOTCLK   gpio_clk   220.07m   6.22nH   0.20pF
N2   LCD_D06   gpio_f   202.44m   5.12nH   0.20pF
N3   VDDIO33   POWER   181.71m   4.48nH   0.19pF
N4   VSS   GND   102.24m   3.69nH   0.09pF
N5   LCD_ENABLE   gpio_f   107.58m   3.09nH   0.14pF
N6   GPMI_RDY0   gpio_f   87.64m   2.24nH   0.19pF
N7   GPMI_CE0N   gpio_f   79.00m   2.03nH   0.24pF
N8   GPMI_RDY1   gpio_f   69.38m   1.74nH   0.19pF
N9   GPMI_CE1N   gpio_f   72.11m   1.82nH   0.19pF
N10   EMI_A14   ddr   69.27m   1.74nH   0.20pF
N11   EMI_A07   ddr   62.85m   1.73nH   0.20pF
N12   EMI_BA2   ddr   71.12m   1.96nH   0.11pF
N13   VDDIO_EMI   POWER   73.97m   2.46nH   0.13pF
N14   EMI_D03   ddr   93.01m   2.50nH   0.12pF
N15   VDDIO_EMI   POWER   87.27m   2.90nH   0.23pF
N16   EMI_D00   ddr   160.17m   3.98nH   0.16pF
N17   VDDIO33_EMI   POWER   157.08m   4.39nH   0.16pF
P1   LCD_D07   gpio_f   234.05m   6.74nH   0.26pF
P2   LCD_D08   gpio_f   218.81m   5.60nH   0.19pF
P3   LCD_D09   gpio_f   191.11m   4.75nH   0.21pF
P4   LCD_RD_E   gpio_f   123.50m   3.89nH   0.23pF
P5   LCD_CS   gpio_f   115.88m   3.65nH   0.25pF
P6   GPMI_ALE   gpio_f   108.46m   3.40nH   0.17pF
P7   GPMI_CLE   gpio_f   97.60m   2.88nH   0.16pF
P8   GPMI_WRN   gpio_clk   87.62m   2.53nH   0.14pF
P9   EMI_CE1N   ddr   95.23m   2.69nH   0.13pF
P10   EMI_A09   ddr   85.67m   2.41nH   0.13pF
P11   VDDIO_EMI   POWER   66.74m   2.25nH   0.15pF
P12   EMI_CE0N   ddr   86.28m   2.52nH   0.15pF
P13   EMI_D04   ddr   157.59m   3.23nH   0.12pF
P14   VSSIO_EMI   GND   163.84m   3.76nH   0.16pF
P15   EMI_D02   ddr   114.58m   3.50nH   0.16pF
P16   VSSIO_EMI   GND   116.53m   3.79nH   0.18pF
P17   EMI_D05   ddr   138.90m   4.54nH   0.23pF
R1   LCD_D10   gpio_f   246.45m   7.09nH   0.28pF
R2   LCD_D11   gpio_f   224.55m   5.96nH   0.20pF
R3   LCD_D17   gpio_f   141.42m   4.78nH   0.24pF
R4   LCD_D20   gpio_f   137.45m   4.38nH   0.23pF
R5   LCD_D23   gpio_f   199.32m   4.81nH   0.21pF
R6   GPMI_RDN   gpio_clk   188.20m   4.34nH   0.20pF
R7   GPMI_D05   gpio_f   179.70m   4.08nH   0.20pF
R8   GPMI_D02   gpio_f   175.34m   3.98nH   0.18pF
R9   EMI_A06   ddr   172.81m   3.96nH   0.17pF
R10   VSSIO_EMI   GND   165.78m   3.86nH   0.20pF
R11   EMI_A05   ddr   174.36m   3.96nH   0.20pF
R12   VSSIO_EMI   GND   169.65m   4.09nH   0.18pF
R13   VDDIO_EMI   POWER   73.97m   2.46nH   0.13pF
R14   EMI_VREF0   POWER   183.87m   4.25nH   0.19pF
R15   VDDIO_EMIQ   POWER   123.26m   4.44nH   0.23pF
R16   EMI_RASN   ddr   153.93m   4.90nH   0.22pF
R17   EMI_ODT0   ddr   153.47m   5.26nH   0.21pF
T1   LCD_D12   gpio_f   252.00m   7.45nH   0.22pF
T2   LCD_D13   gpio_f   230.29m   6.28nH   0.21pF
T3   LCD_D16   gpio_f   233.86m   6.18nH   0.21pF
T4   LCD_D19   gpio_f   224.55m   5.93nH   0.21pF
T5   LCD_D22   gpio_f   221.21m   5.88nH   0.20pF
T6   GPMI_D07   gpio_f   209.42m   5.42nH   0.19pF
T7   GPMI_D04   gpio_f   202.22m   5.12nH   0.19pF
T8   GPMI_D01   gpio_f   189.01m   4.70nH   0.17pF
T9   EMI_A13   ddr   189.56m   4.71nH   0.17pF
T10   EMI_A11   ddr   188.82m   4.59nH   0.20pF
T11   EMI_A03   ddr   191.57m   4.66nH   0.17pF
T12   EMI_BA1   ddr   192.67m   4.71nH   0.17pF
T13   EMI_CKE   ddr   196.93m   4.86nH   0.18pF
T14   VSSIO_EMI   GND   187.39m   5.10nH   0.19pF
T15   EMI_WEN   ddr   194.90m   4.94nH   0.19pF
T16   EMI_BA0   ddr   150.33m   5.37nH   0.23pF
T17   EMI_ODT1   ddr   172.65m   5.73nH   0.21pF
U1   VSS   GND   102.24m   3.69nH   0.09pF
U2   LCD_D14   gpio_f   257.61m   7.24nH   0.21pF
U3   LCD_D15   gpio_f   247.57m   6.95nH   0.20pF
U4   LCD_D18   gpio_f   242.09m   6.73nH   0.20pF
U5   LCD_D21   gpio_f   230.00m   6.27nH   0.19pF
U6   GPMI_D06   gpio_f   226.45m   6.16nH   0.19pF
U7   GPMI_D03   gpio_f   215.69m   5.71nH   0.18pF
U8   GPMI_D00   gpio_f   207.27m   5.37nH   0.17pF
U9   EMI_A08   ddr   207.46m   5.36nH   0.17pF
U10   EMI_A04   ddr   204.68m   5.28nH   0.17pF
U11   EMI_A12   ddr   206.93m   5.37nH   0.18pF
U12   EMI_A01   ddr   207.87m   5.37nH   0.17pF
U13   EMI_A10   ddr   213.19m   5.59nH   0.18pF
U14   EMI_A02   ddr   221.88m   5.94nH   0.19pF
U15   EMI_A00   ddr   227.97m   6.18nH   0.19pF
U16   EMI_CASN   ddr   235.20m   6.47nH   0.20pF
U17   VSSIO_EMI   GND   154.19m   6.13nH   0.24pF
[Pin Mapping]   pulldown_ref   pullup_ref
A1   GND   NC
A2   GND   VDDIO33
A3   GND   VDDIO33
A4   GND   VDDIO33
A5   GND   VDDIO33
A6   GND   VDDIO33
A7   NC   VDDIO33
A8   GND   NC
A9   GND   NC
A10   GND   NC
A11   GND   NC
A12   GND   NC
A13   NC   VDD4P2
A14   GND   NC
A15   GND   NC
A16   GND   NC
A17   GND   NC
B1   GND   VDDIO33
B2   GND   VDDIO33
B3   GND   VDDIO33
B4   GND   VDDIO33
B5   GND   VDDIO33
B6   GND   VDDIO33
B7   GND   NC
B8   GND   NC
B9   GND   VDDIO33
B10   GND   NC
B11   GND   NC
B12   GND   NC
B13   GND   NC
B14   GND   NC
B15   GND   NC
B16   GND   NC
B17   GND   NC
C1   GND   VDDIO33
C2   GND   VDDIO33
C3   GND   VDDIO33
C4   GND   VDDIO33
C5   GND   VDDIO33
C6   GND   VDDIO33
C7   GND   VDDIO33
C8   GND   NC
C9   GND   NC
C10   GND   VDDIO33
C11   GND   NC
C12   NC   VDDXTAL
C13   NC   VDDA1
C14   GND   NC
C15   GND   NC
C16   GND   NC
C17   GND   NC
D1   GND   VDDIO33
D2   GND   VDDIO33
D3   GND   VDDIO33
D4   GND   VDDIO33
D5   GND   VDDIO33
D6   GND   VDDIO33
D7   GND   VDDIO33
D8   GND   VDDIO33
D9   GND   NC
D10   GND   VDDIO33
D11   GND   NC
D12   GND   VDDIO33
D13   GND   NC
D14   GND   VDDIO33
D15   GND   NC
D16   NC   VDD1P5
D17   GND   NC
E1   GND   VDDIO33
E2   GND   VDDIO33
E3   GND   VDDIO33
E4   GND   VDDIO33
E5   GND   NC
E6   NC   VDDIO33
E7   GND   VDDIO33
E8   GND   VDDIO33
E9   GND   VDDIO33
E10   GND   VDDIO33
E11   GND   VDDIO33
E12   GND   VDDIO33
E13   GND   VDDIO33
E14   GND   VDDIO33
E15   GND   NC
E16   NC   VDDIO33
E17   NC   VDD5V
F1   GND   VDDIO33
F2   GND   VDDIO33
F3   GND   VDDIO33
F4   GND   VDDIO33
F5   GND   VDDIO33
F6   GND   VDDIO33
F7   GND   VDDIO33
F8   NC   VDDIO18
F9   NC   VDDIO18
F10   NC   VDDD
F11   NC   VDDD
F12   NC   VDDD
F13   GND   VDDIO_EMI
F14   GND   NC
F15   GND   VDDIO_EMI
F16   GND   NC
F17   GND   VDDIO_EMI
G1   GND   VDDIO33
G2   GND   VDDIO33
G3   NC   VDDIO33
G4   GND   VDDIO33
G5   GND   VDDIO33
G6   GND   VDDIO33
G7   GND   VDDIO33
G8   NC   VDDIO18
G9   NC   VDDIO18
G10   NC   VDDD
G11   NC   VDDD
G12   NC   VDDD
G13   NC   VDDIO_EMI
G14   GND   VDDIO_EMI
G15   NC   VDDIO_EMI
G16   GND   VDDIO_EMI
G17   NC   VDDIO_EMI
H1   GND   VDDIO33
H2   GND   VDDIO33
H3   GND   NC
H4   GND   VDDIO33
H5   GND   VDDIO33
H6   GND   VDDIO33
H7   GND   VDDIO33
H8   NC   VDDIO33
H9   GND   NC
H10   GND   NC
H11   GND   NC
H12   GND   NC
H13   GND   VDDIO_EMI
H14   GND   NC
H15   GND   VDDIO_EMI
H16   GND   NC
H17   GND   VDDIO_EMI
J1   GND   VDDIO33
J2   GND   VDDIO33
J3   GND   VDDIO33
J4   GND   VDDIO33
J5   GND   VDDIO33
J6   GND   VDDIO33
J7   GND   VDDIO33
J8   NC   VDDIO33
J9   NC   VDDIO33
J10   NC   VDDIO33
J11   GND   NC
J12   GND   NC
J13   NC   VDDIO_EMIQ
J14   GND   VDDIO_EMI
J15   GND   NC
J16   GND   VDDIO_EMI
J17   GND   VDDIO_EMI
K1   GND   VDDIO33
K2   GND   VDDIO33
K3   GND   VDDIO33
K4   GND   VDDIO33
K5   GND   VDDIO33
K6   GND   VDDIO33
K7   GND   VDDIO33
K8   GND   VDDIO33
K9   GND   NC
K10   GND   NC
K11   GND   NC
K12   NC   VDDD
K13   NC   EMI_VREF1
K14   GND   VDDIO_EMI
K15   NC   VDDIO_EMIQ
K16   GND   VDDIO_EMI
K17   GND   VDDIO_EMI
L1   GND   VDDIO33
L2   GND   VDDIO33
L3   GND   VDDIO33
L4   GND   VDDIO33
L5   GND   VDDIO33
L6   GND   VDDIO33
L7   GND   VDDIO33
L8   GND   VDDIO33
L9   GND   VDDIO33
L10   GND   NC
L11   GND   NC
L12   GND   NC
L13   NC   VDDIO_EMI
L14   GND   VDDIO_EMI
L15   GND   VDDIO_EMI
L16   GND   VDDIO_EMI
L17   GND   VDDIO_EMI
M1   GND   VDDIO33
M2   GND   VDDIO33
M3   GND   VDDIO33
M4   GND   VDDIO33
M5   GND   VDDIO33
M6   GND   VDDIO33
M7   GND   VDDIO33
M8   GND   VDDIO33
M9   GND   VDDIO33
M10   NC   VDDIO_EMI
M11   NC   VDDIO_EMI
M12   NC   VDDIO_EMI
M13   GND   VDDIO_EMI
M14   GND   NC
M15   GND   VDDIO_EMI
M16   GND   NC
M17   GND   VDDIO_EMI
N1   GND   VDDIO33
N2   GND   VDDIO33
N3   NC   VDDIO33
N4   GND   NC
N5   GND   VDDIO33
N6   GND   VDDIO33
N7   GND   VDDIO33
N8   GND   VDDIO33
N9   GND   VDDIO33
N10   GND   VDDIO_EMI
N11   GND   VDDIO_EMI
N12   GND   VDDIO_EMI
N13   NC   VDDIO_EMI
N14   GND   VDDIO_EMI
N15   NC   VDDIO_EMI
N16   GND   VDDIO_EMI
N17   NC   VDDIO33_EMI
P1   GND   VDDIO33
P2   GND   VDDIO33
P3   GND   VDDIO33
P4   GND   VDDIO33
P5   GND   VDDIO33
P6   GND   VDDIO33
P7   GND   VDDIO33
P8   GND   VDDIO33
P9   GND   VDDIO_EMI
P10   GND   VDDIO_EMI
P11   NC   VDDIO_EMI
P12   GND   VDDIO_EMI
P13   GND   VDDIO_EMI
P14   GND   NC
P15   GND   VDDIO_EMI
P16   GND   NC
P17   GND   VDDIO_EMI
R1   GND   VDDIO33
R2   GND   VDDIO33
R3   GND   VDDIO33
R4   GND   VDDIO33
R5   GND   VDDIO33
R6   GND   VDDIO33
R7   GND   VDDIO33
R8   GND   VDDIO33
R9   GND   VDDIO_EMI
R10   GND   NC
R11   GND   VDDIO_EMI
R12   GND   NC
R13   NC   VDDIO_EMI
R14   NC   EMI_VREF0
R15   NC   VDDIO_EMIQ
R16   GND   VDDIO_EMI
R17   GND   VDDIO_EMI
T1   GND   VDDIO33
T2   GND   VDDIO33
T3   GND   VDDIO33
T4   GND   VDDIO33
T5   GND   VDDIO33
T6   GND   VDDIO33
T7   GND   VDDIO33
T8   GND   VDDIO33
T9   GND   VDDIO_EMI
T10   GND   VDDIO_EMI
T11   GND   VDDIO_EMI
T12   GND   VDDIO_EMI
T13   GND   VDDIO_EMI
T14   GND   NC
T15   GND   VDDIO_EMI
T16   GND   VDDIO_EMI
T17   GND   VDDIO_EMI
U1   GND   NC
U2   GND   VDDIO33
U3   GND   VDDIO33
U4   GND   VDDIO33
U5   GND   VDDIO33
U6   GND   VDDIO33
U7   GND   VDDIO33
U8   GND   VDDIO33
U9   GND   VDDIO_EMI
U10   GND   VDDIO_EMI
U11   GND   VDDIO_EMI
U12   GND   VDDIO_EMI
U13   GND   VDDIO_EMI
U14   GND   VDDIO_EMI
U15   GND   VDDIO_EMI
U16   GND   VDDIO_EMI
U17   GND   NC
|*   Model Selector   *
[Model Selector] ddr_clk
lvddr2_clk_ds00   lvddr2_clk ds00
lvddr2_clk_ds01   lvddr2_clk ds01
lvddr2_clk_ds10   lvddr2_clk ds10
mddr_clk_ds00   mddr_clk ds00
mddr_clk_ds01   mddr_clk ds01
mddr_clk_ds10   mddr_clk ds10
ddr2_clk_ds00   ddr2_clk ds00
ddr2_clk_ds01   ddr2_clk ds01
ddr2_clk_ds10   ddr2_clk ds10
[Model Selector] ddr
lvddr2_dq_ds00   lvddr2_dq ds00
lvddr2_dq_ds01   lvddr2_dq ds01
lvddr2_dq_ds10   lvddr2_dq ds10
mddr_dq_ds00   mddr_dq ds00
mddr_dq_ds01   mddr_dq ds01
mddr_dq_ds10   mddr_dq ds10
ddr2_dq_ds00   ddr2_dq ds00
ddr2_dq_ds01   ddr2_dq ds01
ddr2_dq_ds10   ddr2_dq ds10
[Model Selector] gpio_clk
gpio_clk_1p8_ds0x   gpio_clk 1p8 medium
gpio_clk_1p8_ds10   gpio_clk 1p8 very high
gpio_clk_3p3_ds0x   gpio_clk 3p3 medium
gpio_clk_3p3_ds10   gpio_clk 3p3 very high
[Model Selector] gpio_f
gpio_f_1p8_ds00   gpio_f 1p8 low
gpio_f_1p8_ds01   gpio_f 1p8 medium
gpio_f_1p8_ds10   gpio_f 1p8 high
gpio_f_3p3_ds00   gpio_f 3p3 low
gpio_f_3p3_ds01   gpio_f 3p3 medium
gpio_f_3p3_ds10   gpio_f 3p3 high
[Model Selector] gpio
gpio_1p8_ds00   gpio 1p8  low
gpio_1p8_ds01   gpio 1p8  medium
gpio_1p8_ds10   gpio 1p8  high
gpio_3p3_ds00   gpio 3p3  low
gpio_3p3_ds01   gpio 3p3  medium
gpio_3p3_ds10   gpio 3p3  high
| End [Component] 289MAPBGA14x14
| Models and submodels in the file (34): gpio_1p8_ds10 (I/O), gpio_1p8_ds00 (I/O), gpio_1p8_ds01 (I/O), gpio_3p3_ds10 (I/O), gpio_3p3_ds00 (I/O), gpio_3p3_ds01 (I/O), gpio_clk_1p8_ds10 (I/O), gpio_clk_1p8_ds0x (I/O), gpio_clk_3p3_ds10 (I/O), gpio_clk_3p3_ds0x (I/O), gpio_f_1p8_ds10 (I/O), gpio_f_1p8_ds00 (I/O), gpio_f_1p8_ds01 (I/O), gpio_f_3p3_ds10 (I/O), gpio_f_3p3_ds00 (I/O), gpio_f_3p3_ds01 (I/O), lvddr2_clk_ds10 (I/O), lvddr2_clk_ds01 (I/O), lvddr2_clk_ds00 (I/O), lvddr2_dq_ds10 (I/O), lvddr2_dq_ds00 (I/O), mddr_clk_ds10 (I/O), mddr_clk_ds00 (I/O), mddr_dq_ds10 (I/O), mddr_dq_ds01 (I/O), mddr_dq_ds00 (I/O), ddr2_clk_ds10 (I/O), ddr2_clk_ds01 (I/O), ddr2_clk_ds00 (I/O), ddr2_dq_ds10 (I/O), ddr2_dq_ds01 (I/O), ddr2_dq_ds00 (I/O), mddr_clk_ds01 (I/O), lvddr2_dq_ds01 (I/O)
